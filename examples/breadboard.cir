* Two-pole RC low-pass, jellybean parts, corners in the audio band.
*
* Rsrc and Rin are not on the breadboard: they are the interface's own
* output and input impedance.  Leaving them out is the usual reason a
* real measurement refuses to match a netlist that looks correct.
* Measure yours, or start from these and check the nominal board comes
* back as nominal.  They are also not parts you soldered, so pass
*   --exclude Rsrc,Rin
* and they stop competing to explain a fault they cannot have.
*
V1   gen 0   AC 1
Rsrc gen in  100
R1   in  a   10k
C1   a   0   10n
R2   a   out 10k
C2   out 0   10n
Rin  out 0   100k
.end
